# Ansys Electronics Desktop project, version 2023.2
materials:
  vacuum: permittivity=1
  air: permittivity=1.0006 permeability=1.0000004
  copper: permeability=0.999991 conductivity=58000000

design WPT coil (Maxwell 3D, Magnetostatic, model units mm)
variables:
  distt = 55mm
  i = 5A
  plate = 65mm
geometry:
  Tx [copper] = user_primitive(SegmentedHelix/PolygonHelix.dll, PolygonSegments=0, PolygonRadius=3mm, StartHelixRadius=40mm, RadiusChange=0mm, Pitch=8.01mm, Turns=3, SegmentsPerTurn=36, RightHanded=1)
  Polyline1 = polyline(z=24.03mm, xy in mm: (39.847788, 0) (39.847788, 5) (500, 5), section circle width=2mm)
  Polyline2 = polyline(z=0mm, xy in mm: (39.846625, 0) (39.846625, -5) (500, -5), section circle width=2mm)
  region [air] = box(corner=(-140mm, -140mm, -140mm), size=(280mm, 280mm, 300mm))
  Box2 = box(corner=(140mm, -140mm, 160mm), size=(460mm, 280mm, -300mm))
  Tx.unite(Polyline1, Polyline2)
  Tx.subtract(Box2)
  Rx [copper] = user_primitive(SegmentedHelix/PolygonHelix.dll, PolygonSegments=0, PolygonRadius=3mm, StartHelixRadius=40mm, RadiusChange=0mm, Pitch=8.01mm, Turns=3, SegmentsPerTurn=36, RightHanded=1)
  Polyline3 = polyline(z=24.03mm, xy in mm: (39.847788, 0) (39.847788, 5) (500, 5), section circle width=2mm)
  Polyline4 = polyline(z=0mm, xy in mm: (39.846625, 0) (39.846625, -5) (500, -5), section circle width=2mm)
  Rx.unite(Polyline3, Polyline4)
  Box3 = box(corner=(140mm, -140mm, 160mm), size=(460mm, 280mm, -300mm))
  Rx.subtract(Box3)
  Rx.move(0mm, 0mm, distt)
  Rectangle1 [non-model] = rectangle(corner=(-50mm, -60mm, plate), x_size=110mm, y_size=120mm)
boundaries and excitations:
  Tx_in: Current Faces=Tx.face(at (140, -5, 0)) Current=i IsSolid=true Point_out_of_terminal=false
  Tx_out: Current Faces=Tx.face(at (140, 5, 24.03)) Current=i IsSolid=true Point_out_of_terminal=true
  Rx_in: Current Faces=Rx.face(at (140, -5, 55)) Current=0A IsSolid=true Point_out_of_terminal=false
  Rx_out: Current Faces=Rx.face(at (140, 5, 79.03)) Current=0A IsSolid=true Point_out_of_terminal=true
parameters:
  Matrix1: Matrix Rx_in, Tx_in: NumberOfTurns=1
mesh:
  region: LengthBased RefineInside Objects=region MaxLength=100mm
  Coil: LengthBased Objects=[Rx, Tx] MaxLength=20mm
  initial mesh: GlobalSurfApproximation{CurvedSurfaceApproxChoice=UseSlider SliderMeshSettings=1} GlobalCurvilinear{Apply}
setups:
  Setup1: Magnetostatic MaximumPasses=10 MinimumPasses=2 MinimumConvergedPasses=1 PercentRefinement=30 PercentError=10 RelativeResidual=1e-06 NonLinearResidual=0.001
optimetrics:
  ParametricSetup1: Parametric Sim._Setups=[Setup1]
    sweep distt: LIN 35mm 65mm 10mm
field plots:
  Mag_B1, B_Vector1: B over a plane on Setup1 : LastAdaptive
reports:
  L Table 1: Matrix1.L(Rx_in,Rx_in), Matrix1.L(Tx_in,Rx_in), Matrix1.L(Rx_in,Tx_in), Matrix1.L(Tx_in,Tx_in) vs distt on Setup1 : LastAdaptive
  Coupling Coeff Plot 1: CplCoef(Tx_in,Rx_in) vs distt on Setup1 : LastAdaptive; markers m1 at 49.905063mm

design WPT Circuit (Twin Builder)
variables:
  C_in = 37pF
  C_out = 37pF
  R_load = 10ohm
components:
  E_source = E(Type=ESINE AMPL=320V FREQ=6.78MHz PERIO=0 TPERIO=Tend+1)
  I_in = AM()
  V_in = VM()
  LMatrix1 = MaxwellData1(ComponentDataType=MaxwellData name=MaxwellData1 filename="$PROJECTDIR\final swipt.aedt" numberofports=4 CouplingDesignName="WPT coil" CouplingSolutionName="Setup1 : LastAdaptive" CouplingMatrixName=Matrix1 CouplingType=SmlInductance3DLink VariationKey="COMPONENT_SCALE='1' distt='200mm' i='5A' plate='65mm'" ModelText="// BEGIN ANSOFT HEADER / // node Rx_in_src Rx_in:src / // node Tx_in_src Tx_in:src / // node Rx_in_snk Rx_in:snk / // node Tx_in_snk Tx_in:snk / // Project: final swipt / // Design: WPT coil / // Format: Simplorer SML / // Topckt: WPT_coil / // Creator: Ansoft Electronics Desktop Student 2023.2.0 / // Date: Fri Mar 29 17:36:14 2024 / // Notes: Scale = 1 / // : Turns/Resistance Rx_in:src = 1/0 / // : Turns/Resistance Tx_in:src = 1/0 / // END ANSOFT HEADER / SMLDEF MaxwellData1_16 / { / PORT electrical: Rx_in_src ; / PORT electrical: Tx_in_src ; / PORT electrical: Rx_in_snk ; / PORT electrical: Tx_in_snk ; / MODEL WPT_coil_series X1 N_1:=Rx_in_src, N_2:=Tx_in_src, N_3:=Rx_in_snk, \ / N_4:=Tx_in_snk ( ); / SMLDEF WPT_coil_series / { / PORT electrical: N_1 ; / PORT electrical: N_2 ; / PORT electrical: N_3 ; / PORT electrical: N_4 ; / INTERN L L1 N1:=N_1, N2:=N_3 ( L:=1.0599388822e-06 ); / INTERN L L2 N1:=N_2, N2:=N_4 ( L:=1.04912682605e-06 ); / INTERN M K1_2 ( L1:=L1.L, L2:=L2.L, K:=0.094586 ); / } // WPT_coil_series / } // WPT_coil" SolvedVariationKey="WPT coil;Setup1 : LastAdaptive;Matrix1;COMPONENT_SCALE='1' distt='55mm' i='5A' plate='65mm'" MaxNumPoles=10000 ErrT)
  C1 = C(C=C_in)
  C2 = C(C=C_out)
  I_out = AM()
  V_out = VM()
  R1 = R(R=R_load)
nets:
  net_1: E_source.1, I_in.0
  net_2: LMatrix1.1, C1.1
  net_3: LMatrix1.2, R1.1, V_out.1
  net_4: V_in.0, C1.0, I_in.1
  net_5: LMatrix1.0, C2.0
  net_6: C2.1, I_out.0
  net_7: R1.0, V_out.0, I_out.1
  net_8: LMatrix1.3, E_source.0, V_in.1
setups:
  AC: LinearFrequencyData(1, 6MHz, 7MHz, 100Hz)
  TR: TransientData(10ns, 1ps, 100ps, false, "")
reports:
  XY Plot 1: ((mag(V_out.V)*mag(I_out.I))/mag(V_in.V*I_in.I))*100 vs Freq on AC : AC
  XY Plot 2: I_out.I, V_out.V vs Time on TR : TR
